ADE simulation setup
Run mode: Single Run, Sweeps and Corners
Tests:
  IC2_Folded_Cascode:folded_cascode:1: IC2_Folded_Cascode/folded_cascode/schematic, simulator spectre
Global variables:
  VDD = 3.3
  ACMAG = 1
  VINCM = 1.65
  VINCM_AC = 0
  Ln = 1u
  Ln_IN = 0.6u
  Lp = 0.4u
  Vb1 = 2.618569
  Vb2 = 2.464723
  Vb3 = 0.850906
  Wn_IN = 60.524u
  Wn_C = 66.5u
  Wn_CS = 66.5u
  Wp_C = 84.3474u
  Wp_CS = 84.3474u
