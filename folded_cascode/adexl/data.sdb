ADE simulation setup
Run mode: Single Run, Sweeps and Corners
Tests:
  IC2_Folded_Cascode:folded_cascode:1: IC2_Folded_Cascode/folded_cascode/schematic, simulator spectre
Global variables:
  ACMAG = 1
  Ln = 0.5u
  Lp = 0.4u
  Vb1 = 2.57042
  Vb2 = 2.40294
  Vb3 = 0.91996
  VDD = 3.3
  VINCM = 1.65
  Wn_C = 25.61u
  Wn_CS = 15.728u
  Wn_IN = 46.574u
  Wp_C = 38.805u
  Wp_CS = 28.25u
