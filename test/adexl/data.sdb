ADE simulation setup
Run mode: Single Run, Sweeps and Corners
Tests:
  IC2_Folded_Cascode:test:1: IC2_Folded_Cascode/test/schematic, simulator spectre
Global variables:
  Ln = 0.6u
  Lp = 0.4u
  VDS = 1.65
  VGS = 0.5719
  Wn = 10u
  Wp = 10u
